* Circuit Fault Detector — healthy Sallen-Key band-pass baseline.
.include sallen_key_bandpass.inc
.tran 0 50m 0 10u
.end
